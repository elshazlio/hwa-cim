ADE simulation setup
Run mode: Single Run, Sweeps and Corners
Tests:
  ADC_ONLY_THESIS_Two_stage_op_amp_tb_1: ADC_ONLY_THESIS/Two_stage_op_amp_tb/schematic, simulator spectre
    Variables: Vbias = 0.43
