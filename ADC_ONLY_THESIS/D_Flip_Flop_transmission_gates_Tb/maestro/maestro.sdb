ADE simulation setup
Run mode: Single Run, Sweeps and Corners
Tests:
  ADC_ONLY_THESIS_D_Flip_Flop_transmission_gates_Tb_1: ADC_ONLY_THESIS/D_Flip_Flop_transmission_gates_Tb/schematic, simulator spectre
