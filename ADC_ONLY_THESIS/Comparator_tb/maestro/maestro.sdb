ADE simulation setup
Run mode: Single Run, Sweeps and Corners
Tests:
  ADC_ONLY_THESIS_Comparator_tb_1: ADC_ONLY_THESIS/Comparator_tb/schematic, simulator spectre
