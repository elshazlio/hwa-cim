ADE simulation setup
Run mode: Single Run, Sweeps and Corners
Tests:
  ADC_ONLY_THESIS_R-2R_DAC_TB_1: ADC_ONLY_THESIS/R-2R_DAC_TB/schematic, simulator spectre
