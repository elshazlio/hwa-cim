ADE simulation setup
Run mode: Single Run, Sweeps and Corners
Tests:
  ADC_ONLY_THESIS_Inverter_1: ADC_ONLY_THESIS/Inverter/schematic, simulator spectre
    Variables: WP = 146n
    Outputs: TP
