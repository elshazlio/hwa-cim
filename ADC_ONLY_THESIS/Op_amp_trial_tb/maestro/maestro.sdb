ADE simulation setup
Run mode: Single Run, Sweeps and Corners
Tests:
  ADC_ONLY_THESIS_Op_amp_trial_tb_1: ADC_ONLY_THESIS/Op_amp_trial_tb/schematic, simulator spectre
