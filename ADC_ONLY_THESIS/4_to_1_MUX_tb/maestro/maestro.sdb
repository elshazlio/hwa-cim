ADE simulation setup
Run mode: Single Run, Sweeps and Corners
Tests:
  ADC_ONLY_THESIS_4_to_1_MUX_tb_1: ADC_ONLY_THESIS/4_to_1_MUX_tb/schematic, simulator spectre
