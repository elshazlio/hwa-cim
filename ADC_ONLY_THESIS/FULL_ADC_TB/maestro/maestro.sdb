ADE simulation setup
Run mode: Single Run, Sweeps and Corners
Tests:
  ADC_ONLY_THESIS_FULL_ADC_TB_1: ADC_ONLY_THESIS/FULL_ADC_TB/schematic, simulator spectre
