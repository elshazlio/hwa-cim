ADE simulation setup
Run mode: Single Run, Sweeps and Corners
Tests:
  HAJO_OR_static_v1_1: HAJO/OR_static_v1/schematic, simulator spectre
    Variables: Wn = 80n*2; Wp = 80n*5.554778
    Outputs: pavg; iavg; iavg1; iavg2; tp
