ADE simulation setup
Run mode: Single Run, Sweeps and Corners
Tests:
  ADC_ONLY_THESIS_Sample_and_hold_tb_1: ADC_ONLY_THESIS/Sample_and_hold_tb/schematic, simulator spectre
