ADE simulation setup
Run mode: Single Run, Sweeps and Corners
Tests:
  ADC_ONLY_THESIS_SAR_LOGIC_TB_1: ADC_ONLY_THESIS/SAR_LOGIC_TB/schematic, simulator spectre
