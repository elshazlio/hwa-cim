ADE simulation setup
Run mode: Single Run, Sweeps and Corners
Tests:
  Thesis_SRAM_NEW_6t_Sram_Single_Bit_Complete_Tb_1: Thesis_SRAM_NEW/6t_Sram_Single_Bit_Complete_Tb/schematic, simulator spectre
