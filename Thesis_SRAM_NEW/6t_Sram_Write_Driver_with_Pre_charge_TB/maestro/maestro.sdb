ADE simulation setup
Run mode: Single Run, Sweeps and Corners
Tests:
  Thesis_SRAM_NEW_6t_Sram_Write_Driver_with_Pre_charge_TB_1: Thesis_SRAM_NEW/6t_Sram_Write_Driver_with_Pre_charge_TB/schematic, simulator spectre
