ADE simulation setup
Test Thesis_SRAM_NEW_6t_Sram_4x4_FULL_ARRAY_With_C2C_Ladder_With_ACDC_TB_1: Thesis_SRAM_NEW/6t_Sram_4x4_FULL_ARRAY_With_C2C_Ladder_With_ACDC_TB/schematic, simulator spectre
  Models: /eda/cadence/UMC/65/_G-01-LOGIC_MIXED_MODE65N-SP_LOW_K/Designkits/Cadence_IC6/umc65sp/../Models/Spectre/l65sp_v132.lib.scs[tt_sp_lvt11, tt_sp_rvt11, tt_sp_hvt11, tt_sp_shvt11, tt_sp_io18, tt_sp_io25od33, tt_sp_io33, tt_sp_nvt11, tt_sp_nvt18, tt_sp_nvt25od33, tt_sp_nvt33, tt_sp_ncap11, tt_sp_ncap18, tt_sp_ncap25, tt_sp_ncap33, tt_sp_diode, tt_sp_bjt, tt_65_momcaps, tt_sp_res], /eda/cadence/UMC/65/_G-01-LOGIC_MIXED_MODE65N-SP_LOW_K/Designkits/Cadence_IC6/umc65sp/../Models/Spectre/L65_MIMCAPS_20F_KF_V101_RF.lib.scs[tt], /eda/cadence/UMC/65/_G-01-LOGIC_MIXED_MODE65N-SP_LOW_K/Designkits/Cadence_IC6/umc65sp/../Models/Spectre/L65SP_RNNPO_VT01_RF.lib.scs[typ], /eda/cadence/UMC/65/_G-01-LOGIC_MIXED_MODE65N-SP_LOW_K/Designkits/Cadence_IC6/umc65sp/../Models/Spectre/L65SP_RNPPO_VT01_RF.lib.scs[typ], /eda/cadence/UMC/65/_G-01-LOGIC_MIXED_MODE65N-SP_LOW_K/Designkits/Cadence_IC6/umc65sp/../Models/Spectre/L65SP_RNHR_VT01_RF.lib.scs[typ], /eda/cadence/UMC/65/_G-01-LOGIC_MIXED_MODE65N-SP_LOW_K/Designkits/Cadence_IC6/umc65sp/../Models/Spectre/L65SP_RVT10_RF_V101.lib.scs[tt], /eda/cadence/UMC/65/_G-01-LOGIC_MIXED_MODE65N-SP_LOW_K/Designkits/Cadence_IC6/umc65sp/../Models/Spectre/L65SP_IO18_V021_RF.lib.scs[tt], /eda/cadence/UMC/65/_G-01-LOGIC_MIXED_MODE65N-SP_LOW_K/Designkits/Cadence_IC6/umc65sp/../Models/Spectre/L65SP_IO25_V101_RF.lib.scs[tt], /eda/cadence/UMC/65/_G-01-LOGIC_MIXED_MODE65N-SP_LOW_K/Designkits/Cadence_IC6/umc65sp/../Models/Spectre/L65SP_IO33_V101_RF.lib.scs[tt], /eda/cadence/UMC/65/_G-01-LOGIC_MIXED_MODE65N-SP_LOW_K/Designkits/Cadence_IC6/umc65sp/../Models/Spectre/L65_pad_rf_V101.lib.scs[typ], /eda/cadence/UMC/65/_G-01-LOGIC_MIXED_MODE65N-SP_LOW_K/Designkits/Cadence_IC6/umc65sp/../Models/Spectre/L65SP_VARMIS11_V101_RF.lib.scs[typ], /eda/cadence/UMC/65/_G-01-LOGIC_MIXED_MODE65N-SP_LOW_K/Designkits/Cadence_IC6/umc65sp/../Models/Spectre/L65SP_VARMIS18_V021_RF.LIB.SCS[typ], /eda/cadence/UMC/65/_G-01-LOGIC_MIXED_MODE65N-SP_LOW_K/Designkits/Cadence_IC6/umc65sp/../Models/Spectre/L65SP_VARMIS25_RF_V101.lib.scs[typ], /eda/cadence/UMC/65/_G-01-LOGIC_MIXED_MODE65N-SP_LOW_K/Designkits/Cadence_IC6/umc65sp/../Models/Spectre/L65SP_VARMIS33_V101_RF.lib.scs[typ], /eda/cadence/UMC/65/_G-01-LOGIC_MIXED_MODE65N-SP_LOW_K/Designkits/Cadence_IC6/umc65sp/../Models/Spectre/momcaps_array_vp3_rfvcl_V101.lib.scs[typ], /eda/cadence/UMC/65/_G-01-LOGIC_MIXED_MODE65N-SP_LOW_K/Designkits/Cadence_IC6/umc65sp/../Models/Spectre/momcaps_array_vp4_rfvcl_V101.lib.scs[typ], /eda/cadence/UMC/65/_G-01-LOGIC_MIXED_MODE65N-SP_LOW_K/Designkits/Cadence_IC6/umc65sp/../Models/Spectre/momcaps_array_vp5_rfvcl_V101.lib.scs[typ]
  Temperature: 27
  Initial conditions: /Q_ring_6_EOC = 0; /Q_ring_5 = 0; /Q_ring_4 = 0; /Q_ring_3 = 0; /Q_ring_2 = 0; /Q_ring_1 = 1.1
  Analysis tran: stop=4u
  Signals: /A0, /A1, /CLK, /WE, /EN, /Data_In_1, /Data_In_2, /Data_In_3, /Data_In_4, /IA_AnalogR1, /IA_AnalogR2, /IA_AnalogR3, /IA_AnalogR4, /D0_R1, /D1_R1, /D2_R1, /D3_R1, /D0_R2, /D1_R2, /D2_R2, /D3_R2, /D0_R3, /D1_R3, /D2_R3, /D3_R3, /D0_R4, /D1_R4, /D2_R4, /D3_R4, /Q4R4, /Q4R3, /Q4R2, /Q4R1, /Q3R1, /Q3R2, /Q3R4, /Q3R3, /Q2R1, /Q2R2, /Q2R3, /Q2R4, /Q1R1, /Q1R2, /Q1R3, /Q1R4, /Q_ring_1, /Q_ring_2, /Q_ring_3, /Q_ring_4, /Q_ring_5, /Q_ring_6, /OA_Charge, /ADC_OUT_D0, /ADC_OUT_D1, /ADC_OUT_D2, /ADC_OUT_D3, /I0/I4/I2/net3
Run mode: Single Run, Sweeps and Corners
