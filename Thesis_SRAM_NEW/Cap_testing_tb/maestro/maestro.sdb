ADE simulation setup
Run mode: Single Run, Sweeps and Corners
Tests:
  Thesis_SRAM_NEW_Cap_testing_tb_1: Thesis_SRAM_NEW/Cap_testing_tb/schematic, simulator spectre
    Outputs: Z
