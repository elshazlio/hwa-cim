ADE simulation setup
Test Thesis_SRAM_NEW_Cap_testing_tb_1: Thesis_SRAM_NEW/Cap_testing_tb/schematic, simulator spectre
  Models: /eda/cadence/UMC/65/_G-01-LOGIC_MIXED_MODE65N-SP_LOW_K/Designkits/Cadence_IC6/umc65sp/../Models/Spectre/l65sp_v132.lib.scs[tt_sp_lvt11, tt_sp_rvt11, tt_sp_hvt11, tt_sp_shvt11, tt_sp_io18, tt_sp_io25od33, tt_sp_io33, tt_sp_nvt11, tt_sp_nvt18, tt_sp_nvt25od33, tt_sp_nvt33, tt_sp_ncap11, tt_sp_ncap18, tt_sp_ncap25, tt_sp_ncap33, tt_sp_diode, tt_sp_bjt, tt_65_momcaps, tt_sp_res], /eda/cadence/UMC/65/_G-01-LOGIC_MIXED_MODE65N-SP_LOW_K/Designkits/Cadence_IC6/umc65sp/../Models/Spectre/L65_MIMCAPS_20F_KF_V101_RF.lib.scs[tt], /eda/cadence/UMC/65/_G-01-LOGIC_MIXED_MODE65N-SP_LOW_K/Designkits/Cadence_IC6/umc65sp/../Models/Spectre/L65SP_RNNPO_VT01_RF.lib.scs[typ], /eda/cadence/UMC/65/_G-01-LOGIC_MIXED_MODE65N-SP_LOW_K/Designkits/Cadence_IC6/umc65sp/../Models/Spectre/L65SP_RNPPO_VT01_RF.lib.scs[typ], /eda/cadence/UMC/65/_G-01-LOGIC_MIXED_MODE65N-SP_LOW_K/Designkits/Cadence_IC6/umc65sp/../Models/Spectre/L65SP_RNHR_VT01_RF.lib.scs[typ], /eda/cadence/UMC/65/_G-01-LOGIC_MIXED_MODE65N-SP_LOW_K/Designkits/Cadence_IC6/umc65sp/../Models/Spectre/L65SP_RVT10_RF_V101.lib.scs[tt], /eda/cadence/UMC/65/_G-01-LOGIC_MIXED_MODE65N-SP_LOW_K/Designkits/Cadence_IC6/umc65sp/../Models/Spectre/L65SP_IO18_V021_RF.lib.scs[tt], /eda/cadence/UMC/65/_G-01-LOGIC_MIXED_MODE65N-SP_LOW_K/Designkits/Cadence_IC6/umc65sp/../Models/Spectre/L65SP_IO25_V101_RF.lib.scs[tt], /eda/cadence/UMC/65/_G-01-LOGIC_MIXED_MODE65N-SP_LOW_K/Designkits/Cadence_IC6/umc65sp/../Models/Spectre/L65SP_IO33_V101_RF.lib.scs[tt], /eda/cadence/UMC/65/_G-01-LOGIC_MIXED_MODE65N-SP_LOW_K/Designkits/Cadence_IC6/umc65sp/../Models/Spectre/L65_pad_rf_V101.lib.scs[typ], /eda/cadence/UMC/65/_G-01-LOGIC_MIXED_MODE65N-SP_LOW_K/Designkits/Cadence_IC6/umc65sp/../Models/Spectre/L65SP_VARMIS11_V101_RF.lib.scs[typ], /eda/cadence/UMC/65/_G-01-LOGIC_MIXED_MODE65N-SP_LOW_K/Designkits/Cadence_IC6/umc65sp/../Models/Spectre/L65SP_VARMIS18_V021_RF.LIB.SCS[typ], /eda/cadence/UMC/65/_G-01-LOGIC_MIXED_MODE65N-SP_LOW_K/Designkits/Cadence_IC6/umc65sp/../Models/Spectre/L65SP_VARMIS25_RF_V101.lib.scs[typ], /eda/cadence/UMC/65/_G-01-LOGIC_MIXED_MODE65N-SP_LOW_K/Designkits/Cadence_IC6/umc65sp/../Models/Spectre/L65SP_VARMIS33_V101_RF.lib.scs[typ], /eda/cadence/UMC/65/_G-01-LOGIC_MIXED_MODE65N-SP_LOW_K/Designkits/Cadence_IC6/umc65sp/../Models/Spectre/momcaps_array_vp3_rfvcl_V101.lib.scs[typ], /eda/cadence/UMC/65/_G-01-LOGIC_MIXED_MODE65N-SP_LOW_K/Designkits/Cadence_IC6/umc65sp/../Models/Spectre/momcaps_array_vp4_rfvcl_V101.lib.scs[typ], /eda/cadence/UMC/65/_G-01-LOGIC_MIXED_MODE65N-SP_LOW_K/Designkits/Cadence_IC6/umc65sp/../Models/Spectre/momcaps_array_vp5_rfvcl_V101.lib.scs[typ]
  Temperature: 27
  Analysis ac: start=1 stop=20M
  Output V = VF("/net1")
  Output I = imag(IF("/I0/IN"))
  Output Z = (V / I)
  Signals: /I0/IN (terminal), /net1
Run mode: Single Run, Sweeps and Corners
