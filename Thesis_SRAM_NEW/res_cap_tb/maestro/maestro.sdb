ADE simulation setup
Run mode: Single Run, Sweeps and Corners
Tests:
  Thesis_SRAM_NEW_res_cap_tb_1: Thesis_SRAM_NEW/res_cap_tb/schematic, simulator spectre
